0V-eleven_positive-1us
VDD A3V3 0 PWL(0 0 1m 3.6 10m 3.6 0.010001 0 12m 0)
Rtop A3V3 VBIAS 4653
Rbottom VBIAS 0 1010
Cref VBIAS 0 1n
.options reltol=1e-5 abstol=1e-13 method=gear
VDUT P1 P12 0
Vtie2 P2 P1 0
Vtie3 P3 P1 0
Vtie4 P4 P1 0
Vtie5 P5 P1 0
Vtie6 P6 P1 0
Vtie7 P7 P1 0
Vtie8 P8 P1 0
Vtie9 P9 P1 0
Vtie10 P10 P1 0
Vtie11 P11 P1 0
Rhi1 P1 MID1 990k
Rlo1 MID1 A1 990k
Rbias1 A1 VBIAS 4747
Cfilter1 A1 0 1n
Rstray1 A1 0 1t
Rhi2 P2 MID2 990k
Rlo2 MID2 A2 990k
Rbias2 A2 VBIAS 4747
Cfilter2 A2 0 1n
Rstray2 A2 0 1t
Rhi3 P3 MID3 990k
Rlo3 MID3 A3 990k
Rbias3 A3 VBIAS 4747
Cfilter3 A3 0 1n
Rstray3 A3 0 1t
Rhi4 P4 MID4 990k
Rlo4 MID4 A4 990k
Rbias4 A4 VBIAS 4747
Cfilter4 A4 0 1n
Rstray4 A4 0 1t
Rhi5 P5 MID5 990k
Rlo5 MID5 A5 990k
Rbias5 A5 VBIAS 4747
Cfilter5 A5 0 1n
Rstray5 A5 0 1t
Rhi6 P6 MID6 990k
Rlo6 MID6 A6 990k
Rbias6 A6 VBIAS 4747
Cfilter6 A6 0 1n
Rstray6 A6 0 1t
Rhi7 P7 MID7 990k
Rlo7 MID7 A7 990k
Rbias7 A7 VBIAS 4747
Cfilter7 A7 0 1n
Rstray7 A7 0 1t
Rhi8 P8 MID8 990k
Rlo8 MID8 A8 990k
Rbias8 A8 VBIAS 4747
Cfilter8 A8 0 1n
Rstray8 A8 0 1t
Rhi9 P9 MID9 990k
Rlo9 MID9 A9 990k
Rbias9 A9 VBIAS 4747
Cfilter9 A9 0 1n
Rstray9 A9 0 1t
Rhi10 P10 MID10 990k
Rlo10 MID10 A10 990k
Rbias10 A10 VBIAS 4747
Cfilter10 A10 0 1n
Rstray10 A10 0 1t
Rhi11 P11 MID11 990k
Rlo11 MID11 A11 990k
Rbias11 A11 VBIAS 4747
Cfilter11 A11 0 1n
Rstray11 A11 0 1t
Rhi12 P12 MID12 990k
Rlo12 MID12 A12 990k
Rbias12 A12 VBIAS 4747
Cfilter12 A12 0 1n
Rstray12 A12 0 1t
Rref VBIAS AREF 4747
CrefADC AREF 0 1n
.tran 100n 12m 0 100n
.end
